ADE simulation setup
Run mode: Single Run, Sweeps and Corners
Tests:
  DETFF_FS_TSPC_DET_1: DETFF/FS_TSPC_DET/schematic, simulator spectre
    Variables: vdd = 1; FS_TSPC_d_delay = 427p; FS_TSPC_d_period = 4.9n
