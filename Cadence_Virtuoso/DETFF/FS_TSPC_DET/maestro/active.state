ADE simulation setup
Test DETFF_FS_TSPC_DET_1: DETFF/FS_TSPC_DET/schematic, simulator spectre
  Models: /mnt/cadence_tools/gpdk045_v_6_0/gpdk045/../models/spectre/gpdk045.scs[mc]
  Variables: vdd = 1; FS_TSPC_d_delay = 427p; FS_TSPC_d_period = 4.9n
  Temperature: 27
  Analysis tran: stop=20n
  Signals: /CLK, /D, /Q, /CDP, /CDN
Run mode: Single Run, Sweeps and Corners
