* +++++++++++++++++++++++++++++++++++++++++++++++++++++++++ *
* CDL Netlist:                                              *
*                                                           *
* Cell Name  : FNC_DET                                      *
* Netlisted  : Tue Apr 14 15:38:07 2026                     *
* PVS Version: 24.10-p035 Thu Aug 22 18:07:17 PDT 2024      *
* +++++++++++++++++++++++++++++++++++++++++++++++++++++++++ *
*.LDD
*.DEVTMPLT 0 MN(g45n1svt) _nmos1v ndiff_conn(D) poly_conn(G) ndiff_conn(S) psubstrate(B)
*.DEVTMPLT 1 MP(g45p1svt) _pmos1v pdiff_conn(D) poly_conn(G) pdiff_conn(S) nwell_conn(B)

* +++++++++++++++++++++++++++++++++++++++++++++++++++++++++ *
* Sub cell: M1_PO_CDNS_776195486880                         *
* +++++++++++++++++++++++++++++++++++++++++++++++++++++++++ *
.subckt M1_PO_CDNS_776195486880 1
** N=1 EP=1 FDC=0
.ends M1_PO_CDNS_776195486880

* +++++++++++++++++++++++++++++++++++++++++++++++++++++++++ *
* Sub cell: M2_M1_CDNS_776195486883                         *
* +++++++++++++++++++++++++++++++++++++++++++++++++++++++++ *
.subckt M2_M1_CDNS_776195486883 1
** N=1 EP=1 FDC=0
.ends M2_M1_CDNS_776195486883

* +++++++++++++++++++++++++++++++++++++++++++++++++++++++++ *
* Sub cell: nmos1v_3_CDNS_776195486880                      *
* +++++++++++++++++++++++++++++++++++++++++++++++++++++++++ *
.subckt nmos1v_3_CDNS_776195486880 1 2 3 4
** N=4 EP=4 FDC=1
M0 4 3 1 2 g45n1svt L=4.5e-08 W=3e-07 AD=4.2e-14 AS=4.2e-14 PD=8.8e-07 PS=8.8e-07 fw=3e-07 sa=1.4e-07 sb=1.4e-07 sca=3.45234 scb=0.000105824 scc=3.48932e-09 $X=0 $Y=0 $dt=0
.ends nmos1v_3_CDNS_776195486880

* +++++++++++++++++++++++++++++++++++++++++++++++++++++++++ *
* Sub cell: pmos1v_3_CDNS_776195486881                      *
* +++++++++++++++++++++++++++++++++++++++++++++++++++++++++ *
.subckt pmos1v_3_CDNS_776195486881 1 2 3 4 5
** N=5 EP=5 FDC=1
M0 2 4 1 3 g45p1svt L=4.5e-08 W=6e-07 AD=8.4e-14 AS=8.4e-14 PD=1.48e-06 PS=1.48e-06 fw=6e-07 sa=1.4e-07 sb=1.4e-07 sca=69.3272 scb=0.0652205 scc=0.00809762 $X=0 $Y=0 $dt=1
.ends pmos1v_3_CDNS_776195486881

* +++++++++++++++++++++++++++++++++++++++++++++++++++++++++ *
* Sub cell: FNC_DET                                         *
* +++++++++++++++++++++++++++++++++++++++++++++++++++++++++ *
.subckt FNC_DET 1 3 17 11 18
** N=23 EP=5 FDC=34
X0 1 M1_PO_CDNS_776195486880 $T=1400 7230 0 0 $X=1300 $Y=7110
X1 2 M1_PO_CDNS_776195486880 $T=3390 8680 0 0 $X=3290 $Y=8560
X2 3 M1_PO_CDNS_776195486880 $T=7050 10290 0 0 $X=6950 $Y=10170
X3 3 M1_PO_CDNS_776195486880 $T=8900 10270 0 0 $X=8800 $Y=10150
X4 4 M1_PO_CDNS_776195486880 $T=10700 8330 0 0 $X=10600 $Y=8210
X5 5 M1_PO_CDNS_776195486880 $T=12280 7030 0 0 $X=12180 $Y=6910
X6 3 M1_PO_CDNS_776195486880 $T=13150 10270 0 0 $X=13050 $Y=10150
X7 4 M1_PO_CDNS_776195486880 $T=14660 9210 0 0 $X=14560 $Y=9090
X8 4 M1_PO_CDNS_776195486880 $T=16530 7730 0 0 $X=16430 $Y=7610
X9 6 M1_PO_CDNS_776195486880 $T=17450 11920 0 0 $X=17350 $Y=11800
X10 6 M1_PO_CDNS_776195486880 $T=18180 9450 0 0 $X=18080 $Y=9330
X11 7 M1_PO_CDNS_776195486880 $T=18830 10260 0 0 $X=18730 $Y=10140
X12 5 M1_PO_CDNS_776195486880 $T=20900 6870 0 0 $X=20800 $Y=6750
X13 5 M1_PO_CDNS_776195486880 $T=22140 7750 0 0 $X=22040 $Y=7630
X14 8 M1_PO_CDNS_776195486880 $T=24300 8710 0 0 $X=24200 $Y=8590
X15 6 M1_PO_CDNS_776195486880 $T=25150 9450 0 0 $X=25050 $Y=9330
X16 6 M1_PO_CDNS_776195486880 $T=26080 9450 0 0 $X=25980 $Y=9330
X17 5 M1_PO_CDNS_776195486880 $T=26870 7750 0 0 $X=26770 $Y=7630
X18 6 M1_PO_CDNS_776195486880 $T=29300 9450 0 0 $X=29200 $Y=9330
X19 4 M1_PO_CDNS_776195486880 $T=31120 7730 0 0 $X=31020 $Y=7610
X20 8 M1_PO_CDNS_776195486880 $T=32930 8710 0 0 $X=32830 $Y=8590
X21 3 M2_M1_CDNS_776195486883 $T=1500 10290 0 0 $X=1420 $Y=10160
X22 3 M2_M1_CDNS_776195486883 $T=5160 10290 0 0 $X=5080 $Y=10160
X23 6 M2_M1_CDNS_776195486883 $T=9610 11920 0 0 $X=9530 $Y=11790
X24 7 M2_M1_CDNS_776195486883 $T=12660 9330 0 0 $X=12580 $Y=9200
X25 4 M2_M1_CDNS_776195486883 $T=12710 8310 0 0 $X=12630 $Y=8180
X26 9 M2_M1_CDNS_776195486883 $T=12770 11340 0 0 $X=12690 $Y=11210
X27 10 M2_M1_CDNS_776195486883 $T=12860 6110 0 0 $X=12780 $Y=5980
X28 4 M2_M1_CDNS_776195486883 $T=14660 8310 0 0 $X=14580 $Y=8180
X29 7 M2_M1_CDNS_776195486883 $T=16540 10270 0 0 $X=16460 $Y=10140
X30 10 M2_M1_CDNS_776195486883 $T=18440 6160 0 0 $X=18360 $Y=6030
X31 4 M2_M1_CDNS_776195486883 $T=18480 7730 0 0 $X=18400 $Y=7600
X32 9 M2_M1_CDNS_776195486883 $T=18480 11390 0 0 $X=18400 $Y=11260
X33 4 M2_M1_CDNS_776195486883 $T=28580 6060 0 0 $X=28500 $Y=5930
X34 4 M2_M1_CDNS_776195486883 $T=28580 11100 0 0 $X=28500 $Y=10970
X35 4 M2_M1_CDNS_776195486883 $T=28990 7730 0 0 $X=28910 $Y=7600
X36 11 11 1 2 nmos1v_3_CDNS_776195486880 $T=2280 4660 0 0 $X=1860 $Y=4100
X37 11 11 2 7 nmos1v_3_CDNS_776195486880 $T=4230 4660 0 0 $X=3810 $Y=4100
X38 11 11 2 12 nmos1v_3_CDNS_776195486880 $T=6170 4660 0 0 $X=5750 $Y=4100
X39 12 11 3 6 nmos1v_3_CDNS_776195486880 $T=7910 4660 0 0 $X=7490 $Y=4100
X40 13 11 4 6 nmos1v_3_CDNS_776195486880 $T=9860 4660 1 180 $X=9350 $Y=4100
X41 12 11 5 13 nmos1v_3_CDNS_776195486880 $T=11820 4660 1 180 $X=11310 $Y=4100
X42 10 11 3 5 nmos1v_3_CDNS_776195486880 $T=13560 4660 0 0 $X=13140 $Y=4100
X43 14 11 4 5 nmos1v_3_CDNS_776195486880 $T=15700 4660 1 180 $X=15190 $Y=4100
X44 10 11 6 14 nmos1v_3_CDNS_776195486880 $T=17490 4660 1 180 $X=16980 $Y=4100
X45 11 11 7 10 nmos1v_3_CDNS_776195486880 $T=19530 4660 1 180 $X=19020 $Y=4100
X46 11 11 5 15 nmos1v_3_CDNS_776195486880 $T=21460 4660 0 0 $X=21040 $Y=4100
X47 16 11 8 15 nmos1v_3_CDNS_776195486880 $T=23770 4660 1 180 $X=23260 $Y=4100
X48 11 11 6 16 nmos1v_3_CDNS_776195486880 $T=25790 4660 1 180 $X=25280 $Y=4100
X49 16 11 5 4 nmos1v_3_CDNS_776195486880 $T=27630 4660 0 0 $X=27210 $Y=4100
X50 15 11 6 4 nmos1v_3_CDNS_776195486880 $T=29750 4660 1 180 $X=29240 $Y=4100
X51 11 11 4 8 nmos1v_3_CDNS_776195486880 $T=31830 4660 0 0 $X=31410 $Y=4100
X52 11 11 8 17 nmos1v_3_CDNS_776195486880 $T=33820 4660 0 0 $X=33400 $Y=4100
X53 18 2 18 1 11 pmos1v_3_CDNS_776195486881 $T=2280 12140 0 0 $X=1860 $Y=11940
X54 18 7 18 2 11 pmos1v_3_CDNS_776195486881 $T=4230 12140 0 0 $X=3810 $Y=11940
X55 18 19 18 2 11 pmos1v_3_CDNS_776195486881 $T=6080 12140 0 0 $X=5660 $Y=11940
X56 19 6 18 3 11 pmos1v_3_CDNS_776195486881 $T=7910 12140 0 0 $X=7490 $Y=11940
X57 20 6 18 4 11 pmos1v_3_CDNS_776195486881 $T=9860 12140 1 180 $X=9350 $Y=11940
X58 19 20 18 5 11 pmos1v_3_CDNS_776195486881 $T=11820 12140 1 180 $X=11310 $Y=11940
X59 9 5 18 3 11 pmos1v_3_CDNS_776195486881 $T=13560 12140 0 0 $X=13140 $Y=11940
X60 21 5 18 4 11 pmos1v_3_CDNS_776195486881 $T=15700 12140 1 180 $X=15190 $Y=11940
X61 9 21 18 6 11 pmos1v_3_CDNS_776195486881 $T=17490 12140 1 180 $X=16980 $Y=11940
X62 18 9 18 7 11 pmos1v_3_CDNS_776195486881 $T=19530 12140 1 180 $X=19020 $Y=11940
X63 18 22 18 5 11 pmos1v_3_CDNS_776195486881 $T=21460 12140 0 0 $X=21040 $Y=11940
X64 23 22 18 8 11 pmos1v_3_CDNS_776195486881 $T=23770 12140 1 180 $X=23260 $Y=11940
X65 18 23 18 6 11 pmos1v_3_CDNS_776195486881 $T=25790 12140 1 180 $X=25280 $Y=11940
X66 23 4 18 5 11 pmos1v_3_CDNS_776195486881 $T=27630 12140 0 0 $X=27210 $Y=11940
X67 22 4 18 6 11 pmos1v_3_CDNS_776195486881 $T=29750 12140 1 180 $X=29240 $Y=11940
X68 18 8 18 4 11 pmos1v_3_CDNS_776195486881 $T=31830 12140 0 0 $X=31410 $Y=11940
X69 18 17 18 8 11 pmos1v_3_CDNS_776195486881 $T=33820 12140 0 0 $X=33400 $Y=11940
.ends FNC_DET
