* +++++++++++++++++++++++++++++++++++++++++++++++++++++++++ *
* CDL Netlist:                                              *
*                                                           *
* Cell Name  : FNC_DET                                      *
* Netlisted  : Tue Apr 14 15:38:07 2026                     *
* PVS Version: 24.10-p035 Thu Aug 22 18:07:17 PDT 2024      *
* +++++++++++++++++++++++++++++++++++++++++++++++++++++++++ *
*.LDD
*.DEVTMPLT 0 MN(g45n1svt) _nmos1v ndiff_conn(D) poly_conn(G) ndiff_conn(S) psubstrate(B)
*.DEVTMPLT 1 MP(g45p1svt) _pmos1v pdiff_conn(D) poly_conn(G) pdiff_conn(S) nwell_conn(B)

* +++++++++++++++++++++++++++++++++++++++++++++++++++++++++ *
* Sub cell: nmos1v_3_CDNS_776195486880                      *
* +++++++++++++++++++++++++++++++++++++++++++++++++++++++++ *
.subckt nmos1v_3_CDNS_776195486880 S_source_0 B_botTap 3 D_drain_1
** N=4 EP=4 FDC=1
M0 D_drain_1 3 S_source_0 B_botTap g45n1svt L=4.5e-08 W=3e-07 AD=4.2e-14 AS=4.2e-14 PD=8.8e-07 PS=8.8e-07 fw=3e-07 sa=1.4e-07 sb=1.4e-07 sca=3.45234 scb=0.000105824 scc=3.48932e-09 $X=0 $Y=0 $dt=0
.ends nmos1v_3_CDNS_776195486880

* +++++++++++++++++++++++++++++++++++++++++++++++++++++++++ *
* Sub cell: pmos1v_3_CDNS_776195486881                      *
* +++++++++++++++++++++++++++++++++++++++++++++++++++++++++ *
.subckt pmos1v_3_CDNS_776195486881 S_source_0 D_drain_1 B_topTap 4
** N=5 EP=4 FDC=1
M0 D_drain_1 4 S_source_0 B_topTap g45p1svt L=4.5e-08 W=6e-07 AD=8.4e-14 AS=8.4e-14 PD=1.48e-06 PS=1.48e-06 fw=6e-07 sa=1.4e-07 sb=1.4e-07 sca=69.3272 scb=0.0652205 scc=0.00809762 $X=0 $Y=0 $dt=1
.ends pmos1v_3_CDNS_776195486881

* +++++++++++++++++++++++++++++++++++++++++++++++++++++++++ *
* Sub cell: FNC_DET                                         *
* +++++++++++++++++++++++++++++++++++++++++++++++++++++++++ *
.subckt FNC_DET CLK D Q gnd vdd
** N=23 EP=5 FDC=34
X36 gnd gnd CLK 2 nmos1v_3_CDNS_776195486880 $T=2280 4660 0 0 $X=1860 $Y=4100
X37 gnd gnd 2 7 nmos1v_3_CDNS_776195486880 $T=4230 4660 0 0 $X=3810 $Y=4100
X38 gnd gnd 2 12 nmos1v_3_CDNS_776195486880 $T=6170 4660 0 0 $X=5750 $Y=4100
X39 12 gnd D 6 nmos1v_3_CDNS_776195486880 $T=7910 4660 0 0 $X=7490 $Y=4100
X40 13 gnd 4 6 nmos1v_3_CDNS_776195486880 $T=9860 4660 1 180 $X=9350 $Y=4100
X41 12 gnd 5 13 nmos1v_3_CDNS_776195486880 $T=11820 4660 1 180 $X=11310 $Y=4100
X42 10 gnd D 5 nmos1v_3_CDNS_776195486880 $T=13560 4660 0 0 $X=13140 $Y=4100
X43 14 gnd 4 5 nmos1v_3_CDNS_776195486880 $T=15700 4660 1 180 $X=15190 $Y=4100
X44 10 gnd 6 14 nmos1v_3_CDNS_776195486880 $T=17490 4660 1 180 $X=16980 $Y=4100
X45 gnd gnd 7 10 nmos1v_3_CDNS_776195486880 $T=19530 4660 1 180 $X=19020 $Y=4100
X46 gnd gnd 5 15 nmos1v_3_CDNS_776195486880 $T=21460 4660 0 0 $X=21040 $Y=4100
X47 16 gnd 8 15 nmos1v_3_CDNS_776195486880 $T=23770 4660 1 180 $X=23260 $Y=4100
X48 gnd gnd 6 16 nmos1v_3_CDNS_776195486880 $T=25790 4660 1 180 $X=25280 $Y=4100
X49 16 gnd 5 4 nmos1v_3_CDNS_776195486880 $T=27630 4660 0 0 $X=27210 $Y=4100
X50 15 gnd 6 4 nmos1v_3_CDNS_776195486880 $T=29750 4660 1 180 $X=29240 $Y=4100
X51 gnd gnd 4 8 nmos1v_3_CDNS_776195486880 $T=31830 4660 0 0 $X=31410 $Y=4100
X52 gnd gnd 8 Q nmos1v_3_CDNS_776195486880 $T=33820 4660 0 0 $X=33400 $Y=4100
X53 vdd 2 vdd CLK pmos1v_3_CDNS_776195486881 $T=2280 12140 0 0 $X=1860 $Y=11940
X54 vdd 7 vdd 2 pmos1v_3_CDNS_776195486881 $T=4230 12140 0 0 $X=3810 $Y=11940
X55 vdd 19 vdd 2 pmos1v_3_CDNS_776195486881 $T=6080 12140 0 0 $X=5660 $Y=11940
X56 19 6 vdd D pmos1v_3_CDNS_776195486881 $T=7910 12140 0 0 $X=7490 $Y=11940
X57 20 6 vdd 4 pmos1v_3_CDNS_776195486881 $T=9860 12140 1 180 $X=9350 $Y=11940
X58 19 20 vdd 5 pmos1v_3_CDNS_776195486881 $T=11820 12140 1 180 $X=11310 $Y=11940
X59 9 5 vdd D pmos1v_3_CDNS_776195486881 $T=13560 12140 0 0 $X=13140 $Y=11940
X60 21 5 vdd 4 pmos1v_3_CDNS_776195486881 $T=15700 12140 1 180 $X=15190 $Y=11940
X61 9 21 vdd 6 pmos1v_3_CDNS_776195486881 $T=17490 12140 1 180 $X=16980 $Y=11940
X62 vdd 9 vdd 7 pmos1v_3_CDNS_776195486881 $T=19530 12140 1 180 $X=19020 $Y=11940
X63 vdd 22 vdd 5 pmos1v_3_CDNS_776195486881 $T=21460 12140 0 0 $X=21040 $Y=11940
X64 23 22 vdd 8 pmos1v_3_CDNS_776195486881 $T=23770 12140 1 180 $X=23260 $Y=11940
X65 vdd 23 vdd 6 pmos1v_3_CDNS_776195486881 $T=25790 12140 1 180 $X=25280 $Y=11940
X66 23 4 vdd 5 pmos1v_3_CDNS_776195486881 $T=27630 12140 0 0 $X=27210 $Y=11940
X67 22 4 vdd 6 pmos1v_3_CDNS_776195486881 $T=29750 12140 1 180 $X=29240 $Y=11940
X68 vdd 8 vdd 4 pmos1v_3_CDNS_776195486881 $T=31830 12140 0 0 $X=31410 $Y=11940
X69 vdd Q vdd 8 pmos1v_3_CDNS_776195486881 $T=33820 12140 0 0 $X=33400 $Y=11940
.ends FNC_DET
