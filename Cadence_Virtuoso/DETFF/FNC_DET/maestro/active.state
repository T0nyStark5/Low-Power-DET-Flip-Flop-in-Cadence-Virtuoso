ADE simulation setup
Test DETFF_FNC_DET_1: DETFF/FNC_DET/schematic, simulator spectre
  Models: /mnt/cadence_tools/gpdk045_v_6_0/gpdk045/../models/spectre/gpdk045.scs[mc]
  Variables: FNC_d_delay = 446p; FNC_d_period = 4.9n; vdd = 1
  Temperature: 27
  Analysis tran: stop=20n errpreset=moderate
  Signals: /CLK, /D, /Q, /CKB, /CKI
Run mode: Single Run, Sweeps and Corners
