ADE simulation setup
Run mode: Single Run, Sweeps and Corners
Tests:
  DETFF_FNC_DET_1: DETFF/FNC_DET/schematic, simulator spectre
    Variables: vdd = 1; FNC_d_delay = 446p; FNC_d_period = 4.9n
