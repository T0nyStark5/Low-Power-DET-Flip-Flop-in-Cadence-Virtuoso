ADE simulation setup
Run mode: Single Run, Sweeps and Corners
Tests:
  DETFF_S_TSPC_DET_hold_1: DETFF/S_TSPC_DET_hold/schematic, simulator spectre
    Variables: clk_dly = 500p; clk_prd = 1n; D_dly = 0; D_prd = 3.53n; vdd = 1
