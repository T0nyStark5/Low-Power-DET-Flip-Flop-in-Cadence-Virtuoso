ADE simulation setup
Run mode: Single Run, Sweeps and Corners
Tests:
  DETFF_FS_TSPC_DET_tb_1: DETFF/FS_TSPC_DET_tb/schematic, simulator spectre
    Variables: c = 1f; Cp = 1n; delay = 100p; Dp = 10n; vdd = 1; D_dly = 100p
    Outputs: /CLK; /D; /Q; VT("/IDP")
Corners:
  model folders: /mnt/cadence_tools/gpdk045_v_6_0/models/spectre
  C0: temperature=27; Cp=1n; Dp=10n; c=1f; delay=100p; vdd=1; gpdk045.scs[tt sf fs]
  C1: temperature=-40; Cp=1n; Dp=10n; c=1f; delay=100p; vdd=1.1; gpdk045.scs[ff]
  C2: temperature=120; Cp=1n; Dp=10n; c=1f; delay=100p; vdd=0.9; gpdk045.scs[ss]
