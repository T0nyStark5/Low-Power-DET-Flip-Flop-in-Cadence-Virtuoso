ADE simulation setup
Test DETFF_FS_TSPC_DET_hold_1: DETFF/FS_TSPC_DET_hold/schematic, simulator spectre
  Models: /mnt/cadence_tools/gpdk045_v_6_0/gpdk045/../models/spectre/gpdk045.scs[mc]
  Variables: clk_dly = 500p; clk_prd = 1n; D_dly = 0; D_prd = 3.53n; vdd = 1
  Temperature: 27
  Analysis tran: stop=10n
  Signals: /CLK, /D, /Q, /CDP, /CDN
Run mode: Single Run, Sweeps and Corners
