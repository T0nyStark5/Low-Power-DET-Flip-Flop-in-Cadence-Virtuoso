* +++++++++++++++++++++++++++++++++++++++++++++++++++++++++ *
* CDL Netlist:                                              *
*                                                           *
* Cell Name  : Proposed_STC_DET                             *
* Netlisted  : Mon Apr 13 06:44:35 2026                     *
* PVS Version: 24.10-p035 Thu Aug 22 18:07:17 PDT 2024      *
* +++++++++++++++++++++++++++++++++++++++++++++++++++++++++ *
*.LDD
*.DEVTMPLT 0 MN(g45n1svt) _nmos1v ndiff_conn(D) poly_conn(G) ndiff_conn(S) psubstrate(B)
*.DEVTMPLT 1 MP(g45p1svt) _pmos1v pdiff_conn(D) poly_conn(G) pdiff_conn(S) nwell_conn(B)

* +++++++++++++++++++++++++++++++++++++++++++++++++++++++++ *
* Sub cell: nmos1v_3_CDNS_776077074430                      *
* +++++++++++++++++++++++++++++++++++++++++++++++++++++++++ *
.subckt nmos1v_3_CDNS_776077074430 S_source_0 D_drain_1 B_botTap 4
** N=4 EP=4 FDC=1
M0 D_drain_1 4 S_source_0 B_botTap g45n1svt L=4.5e-08 W=3e-07 AD=4.2e-14 AS=4.2e-14 PD=8.8e-07 PS=8.8e-07 fw=3e-07 sa=1.4e-07 sb=1.4e-07 sca=3.45234 scb=0.000105824 scc=3.48932e-09 $X=0 $Y=0 $dt=0
.ends nmos1v_3_CDNS_776077074430

* +++++++++++++++++++++++++++++++++++++++++++++++++++++++++ *
* Sub cell: pmos1v_3_CDNS_776077074431                      *
* +++++++++++++++++++++++++++++++++++++++++++++++++++++++++ *
.subckt pmos1v_3_CDNS_776077074431 S_source_0 D_drain_1 B_topTap 4
** N=5 EP=4 FDC=1
M0 D_drain_1 4 S_source_0 B_topTap g45p1svt L=4.5e-08 W=6e-07 AD=8.4e-14 AS=8.4e-14 PD=1.48e-06 PS=1.48e-06 fw=6e-07 sa=1.4e-07 sb=1.4e-07 sca=69.3272 scb=0.0652205 scc=0.00809762 $X=0 $Y=0 $dt=1
.ends pmos1v_3_CDNS_776077074431

* +++++++++++++++++++++++++++++++++++++++++++++++++++++++++ *
* Sub cell: Proposed_STC_DET                                *
* +++++++++++++++++++++++++++++++++++++++++++++++++++++++++ *
.subckt Proposed_STC_DET D Q_b clk gnd vdd
** N=25 EP=5 FDC=42
X78 gnd 2 gnd D nmos1v_3_CDNS_776077074430 $T=3950 6200 0 0 $X=3530 $Y=5640
X79 gnd 3 gnd 2 nmos1v_3_CDNS_776077074430 $T=6040 6200 1 180 $X=5530 $Y=5640
X80 gnd 7 gnd 3 nmos1v_3_CDNS_776077074430 $T=7950 6200 0 0 $X=7530 $Y=5640
X81 gnd 13 gnd clk nmos1v_3_CDNS_776077074430 $T=9950 6200 0 0 $X=9530 $Y=5640
X82 gnd 17 gnd clk nmos1v_3_CDNS_776077074430 $T=11950 6200 0 0 $X=11530 $Y=5640
X83 gnd 16 gnd clk nmos1v_3_CDNS_776077074430 $T=13950 6200 0 0 $X=13530 $Y=5640
X84 gnd 18 gnd clk nmos1v_3_CDNS_776077074430 $T=15950 6200 0 0 $X=15530 $Y=5640
X85 17 6 gnd 5 nmos1v_3_CDNS_776077074430 $T=18040 6200 1 180 $X=17530 $Y=5640
X86 17 12 gnd 7 nmos1v_3_CDNS_776077074430 $T=19950 6200 0 0 $X=19530 $Y=5640
X87 16 8 gnd 2 nmos1v_3_CDNS_776077074430 $T=22040 6200 1 180 $X=21530 $Y=5640
X88 16 11 gnd D nmos1v_3_CDNS_776077074430 $T=23950 6200 0 0 $X=23530 $Y=5640
X89 gnd 9 gnd 10 nmos1v_3_CDNS_776077074430 $T=26040 6200 1 180 $X=25530 $Y=5640
X90 gnd 12 gnd 9 nmos1v_3_CDNS_776077074430 $T=27950 6200 0 0 $X=27530 $Y=5640
X91 gnd 5 gnd 7 nmos1v_3_CDNS_776077074430 $T=29950 6200 0 0 $X=29530 $Y=5640
X92 13 3 gnd 7 nmos1v_3_CDNS_776077074430 $T=32040 6200 1 180 $X=31530 $Y=5640
X93 13 7 gnd 5 nmos1v_3_CDNS_776077074430 $T=33950 6200 0 0 $X=33530 $Y=5640
X94 gnd 10 gnd 11 nmos1v_3_CDNS_776077074430 $T=35950 6200 0 0 $X=35530 $Y=5640
X95 21 11 gnd 8 nmos1v_3_CDNS_776077074430 $T=38040 6200 1 180 $X=37530 $Y=5640
X96 gnd 21 gnd 10 nmos1v_3_CDNS_776077074430 $T=40040 6200 1 180 $X=39530 $Y=5640
X97 18 9 gnd 12 nmos1v_3_CDNS_776077074430 $T=41950 6200 0 0 $X=41530 $Y=5640
X98 gnd Q_b gnd 12 nmos1v_3_CDNS_776077074430 $T=43950 6200 0 0 $X=43530 $Y=5640
X99 vdd 2 vdd D pmos1v_3_CDNS_776077074431 $T=3950 28600 0 0 $X=3530 $Y=28400
X100 24 3 vdd 2 pmos1v_3_CDNS_776077074431 $T=6040 28600 1 180 $X=5530 $Y=28400
X101 24 7 vdd D pmos1v_3_CDNS_776077074431 $T=7950 28600 0 0 $X=7530 $Y=28400
X102 vdd 24 vdd clk pmos1v_3_CDNS_776077074431 $T=9950 28600 0 0 $X=9530 $Y=28400
X103 vdd 14 vdd clk pmos1v_3_CDNS_776077074431 $T=11950 28600 0 0 $X=11530 $Y=28400
X104 vdd 15 vdd clk pmos1v_3_CDNS_776077074431 $T=13950 28600 0 0 $X=13530 $Y=28400
X105 vdd 19 vdd clk pmos1v_3_CDNS_776077074431 $T=15950 28600 0 0 $X=15530 $Y=28400
X106 vdd 6 vdd 5 pmos1v_3_CDNS_776077074431 $T=17950 28600 0 0 $X=17530 $Y=28400
X107 vdd 12 vdd 6 pmos1v_3_CDNS_776077074431 $T=19950 28600 0 0 $X=19530 $Y=28400
X108 vdd 8 vdd 2 pmos1v_3_CDNS_776077074431 $T=22040 28600 1 180 $X=21530 $Y=28400
X109 vdd 11 vdd 8 pmos1v_3_CDNS_776077074431 $T=23950 28600 0 0 $X=23530 $Y=28400
X110 19 9 vdd 10 pmos1v_3_CDNS_776077074431 $T=26040 28600 1 180 $X=25530 $Y=28400
X111 19 12 vdd 11 pmos1v_3_CDNS_776077074431 $T=27950 28600 0 0 $X=27530 $Y=28400
X112 vdd 5 vdd 7 pmos1v_3_CDNS_776077074431 $T=29950 28600 0 0 $X=29530 $Y=28400
X113 25 7 vdd 3 pmos1v_3_CDNS_776077074431 $T=32040 28600 1 180 $X=31530 $Y=28400
X114 vdd 25 vdd 5 pmos1v_3_CDNS_776077074431 $T=34040 28600 1 180 $X=33530 $Y=28400
X115 vdd 10 vdd 11 pmos1v_3_CDNS_776077074431 $T=35950 28600 0 0 $X=35530 $Y=28400
X116 15 8 vdd 11 pmos1v_3_CDNS_776077074431 $T=38040 28600 1 180 $X=37530 $Y=28400
X117 15 11 vdd 10 pmos1v_3_CDNS_776077074431 $T=39950 28600 0 0 $X=39530 $Y=28400
X118 14 6 vdd 12 pmos1v_3_CDNS_776077074431 $T=41950 28600 0 0 $X=41530 $Y=28400
X119 vdd Q_b vdd 12 pmos1v_3_CDNS_776077074431 $T=43950 28600 0 0 $X=43530 $Y=28400
.ends Proposed_STC_DET
