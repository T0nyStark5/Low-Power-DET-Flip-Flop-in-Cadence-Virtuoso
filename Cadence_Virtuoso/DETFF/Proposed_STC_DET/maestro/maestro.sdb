ADE simulation setup
Run mode: Single Run, Sweeps and Corners
Tests:
  DETFF_Proposed_STC_DET_1: DETFF/Proposed_STC_DET/schematic, simulator spectre
    Variables: vdd = 1; Proposed_d_delay = 403.5p; Proposed_d_period = 4.9n
