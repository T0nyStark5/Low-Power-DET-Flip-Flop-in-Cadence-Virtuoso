ADE simulation setup
Test DETFF_Proposed_STC_DET_1: DETFF/Proposed_STC_DET/schematic, simulator spectre
  Models: /mnt/cadence_tools/gpdk045_v_6_0/gpdk045/../models/spectre/gpdk045.scs[mc]
  Variables: Proposed_d_delay = 403.5p; Proposed_d_period = 4.9n; vdd = 1
  Temperature: 27
  Analysis tran: stop=15n
  Signals: /clk, /D, /QT, /Q_b, /MID, /MID_n
Run mode: Single Run, Sweeps and Corners
