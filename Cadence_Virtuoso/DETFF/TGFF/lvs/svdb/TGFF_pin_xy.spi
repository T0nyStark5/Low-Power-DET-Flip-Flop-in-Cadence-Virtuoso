* +++++++++++++++++++++++++++++++++++++++++++++++++++++++++ *
* CDL Netlist:                                              *
*                                                           *
* Cell Name  : TGFF                                         *
* Netlisted  : Wed May  6 15:17:34 2026                     *
* PVS Version: 24.10-p035 Thu Aug 22 18:07:17 PDT 2024      *
* +++++++++++++++++++++++++++++++++++++++++++++++++++++++++ *
*.LDD
*.DEVTMPLT 0 MN(g45n1svt) _nmos1v ndiff_conn(D) poly_conn(G) ndiff_conn(S) psubstrate(B)
*.DEVTMPLT 1 MP(g45p1svt) _pmos1v pdiff_conn(D) poly_conn(G) pdiff_conn(S) nwell_conn(B)

* +++++++++++++++++++++++++++++++++++++++++++++++++++++++++ *
* Sub cell: M1_PO_CDNS_778095050760                         *
* +++++++++++++++++++++++++++++++++++++++++++++++++++++++++ *
.subckt M1_PO_CDNS_778095050760 1
** N=1 EP=1 FDC=0
.ends M1_PO_CDNS_778095050760

* +++++++++++++++++++++++++++++++++++++++++++++++++++++++++ *
* Sub cell: M2_M1_CDNS_778095050761                         *
* +++++++++++++++++++++++++++++++++++++++++++++++++++++++++ *
.subckt M2_M1_CDNS_778095050761 1
** N=1 EP=1 FDC=0
.ends M2_M1_CDNS_778095050761

* +++++++++++++++++++++++++++++++++++++++++++++++++++++++++ *
* Sub cell: M1_PO_CDNS_778095050762                         *
* +++++++++++++++++++++++++++++++++++++++++++++++++++++++++ *
.subckt M1_PO_CDNS_778095050762 1
** N=1 EP=1 FDC=0
.ends M1_PO_CDNS_778095050762

* +++++++++++++++++++++++++++++++++++++++++++++++++++++++++ *
* Sub cell: M2_M1_CDNS_778095050763                         *
* +++++++++++++++++++++++++++++++++++++++++++++++++++++++++ *
.subckt M2_M1_CDNS_778095050763 1
** N=1 EP=1 FDC=0
.ends M2_M1_CDNS_778095050763

* +++++++++++++++++++++++++++++++++++++++++++++++++++++++++ *
* Sub cell: nmos1v_3_CDNS_778095050760                      *
* +++++++++++++++++++++++++++++++++++++++++++++++++++++++++ *
.subckt nmos1v_3_CDNS_778095050760 1 2 3 4
** N=4 EP=4 FDC=1
M0 2 4 1 3 g45n1svt L=4.5e-08 W=3e-07 AD=4.2e-14 AS=4.2e-14 PD=8.8e-07 PS=8.8e-07 fw=3e-07 sa=1.4e-07 sb=1.4e-07 sca=3.45234 scb=0.000105824 scc=3.48932e-09 $X=0 $Y=0 $dt=0
.ends nmos1v_3_CDNS_778095050760

* +++++++++++++++++++++++++++++++++++++++++++++++++++++++++ *
* Sub cell: pmos1v_3_CDNS_778095050761                      *
* +++++++++++++++++++++++++++++++++++++++++++++++++++++++++ *
.subckt pmos1v_3_CDNS_778095050761 1 2 3 4 5
** N=5 EP=5 FDC=1
M0 2 4 1 3 g45p1svt L=4.5e-08 W=6e-07 AD=8.4e-14 AS=8.4e-14 PD=1.48e-06 PS=1.48e-06 fw=6e-07 sa=1.4e-07 sb=1.4e-07 sca=69.3272 scb=0.0652205 scc=0.00809762 $X=0 $Y=0 $dt=1
.ends pmos1v_3_CDNS_778095050761

* +++++++++++++++++++++++++++++++++++++++++++++++++++++++++ *
* Sub cell: TGFF                                            *
* +++++++++++++++++++++++++++++++++++++++++++++++++++++++++ *
.subckt TGFF 1 6 13 9 14
** N=14 EP=5 FDC=24
X0 1 M1_PO_CDNS_778095050760 $T=2010 6610 0 0 $X=1910 $Y=6490
X1 2 M1_PO_CDNS_778095050760 $T=5220 10000 0 0 $X=5120 $Y=9880
X2 3 M1_PO_CDNS_778095050760 $T=15030 5960 0 0 $X=14930 $Y=5840
X3 4 M1_PO_CDNS_778095050760 $T=19520 5970 0 0 $X=19420 $Y=5850
X4 4 M1_PO_CDNS_778095050760 $T=21140 5980 0 0 $X=21040 $Y=5860
X5 4 M1_PO_CDNS_778095050760 $T=23070 5980 0 0 $X=22970 $Y=5860
X6 5 M1_PO_CDNS_778095050760 $T=23090 4920 0 0 $X=22990 $Y=4800
X7 5 M1_PO_CDNS_778095050760 $T=25060 4920 0 0 $X=24960 $Y=4800
X8 2 M2_M1_CDNS_778095050761 $T=6940 15680 0 0 $X=6860 $Y=15430
X9 2 M2_M1_CDNS_778095050761 $T=7060 4910 0 0 $X=6980 $Y=4660
X10 6 M2_M1_CDNS_778095050761 $T=7200 13350 0 0 $X=7120 $Y=13100
X11 7 M2_M1_CDNS_778095050761 $T=9170 14870 0 0 $X=9090 $Y=14620
X12 2 M2_M1_CDNS_778095050761 $T=11350 4910 0 0 $X=11270 $Y=4660
X13 2 M2_M1_CDNS_778095050761 $T=11440 15680 0 0 $X=11360 $Y=15430
X14 7 M2_M1_CDNS_778095050761 $T=12940 3890 0 0 $X=12860 $Y=3640
X15 8 M2_M1_CDNS_778095050761 $T=15000 7390 0 0 $X=14920 $Y=7140
X16 2 M2_M1_CDNS_778095050761 $T=17080 15680 0 0 $X=17000 $Y=15430
X17 7 M2_M1_CDNS_778095050761 $T=17490 3890 0 0 $X=17410 $Y=3640
X18 7 M2_M1_CDNS_778095050761 $T=19110 14870 0 0 $X=19030 $Y=14620
X19 2 M2_M1_CDNS_778095050761 $T=19510 4910 0 0 $X=19430 $Y=4660
X20 2 M1_PO_CDNS_778095050762 $T=6940 15680 0 0 $X=6840 $Y=15430
X21 2 M1_PO_CDNS_778095050762 $T=7060 4910 0 0 $X=6960 $Y=4660
X22 6 M1_PO_CDNS_778095050762 $T=7200 13350 0 0 $X=7100 $Y=13100
X23 7 M1_PO_CDNS_778095050762 $T=9170 14870 0 0 $X=9070 $Y=14620
X24 2 M1_PO_CDNS_778095050762 $T=11350 4910 0 0 $X=11250 $Y=4660
X25 2 M1_PO_CDNS_778095050762 $T=11440 15680 0 0 $X=11340 $Y=15430
X26 7 M1_PO_CDNS_778095050762 $T=12940 3890 0 0 $X=12840 $Y=3640
X27 8 M1_PO_CDNS_778095050762 $T=15000 7390 0 0 $X=14900 $Y=7140
X28 2 M1_PO_CDNS_778095050762 $T=17080 15680 0 0 $X=16980 $Y=15430
X29 7 M1_PO_CDNS_778095050762 $T=17490 3890 0 0 $X=17390 $Y=3640
X30 7 M1_PO_CDNS_778095050762 $T=19110 14870 0 0 $X=19010 $Y=14620
X31 2 M1_PO_CDNS_778095050762 $T=19510 4910 0 0 $X=19410 $Y=4660
X32 7 M2_M1_CDNS_778095050763 $T=6930 14870 0 0 $X=6850 $Y=14740
X33 8 M2_M1_CDNS_778095050763 $T=11020 7390 0 0 $X=10940 $Y=7260
X34 9 2 9 1 nmos1v_3_CDNS_778095050760 $T=3930 2200 0 0 $X=3510 $Y=1640
X35 9 7 9 2 nmos1v_3_CDNS_778095050760 $T=5930 2200 0 0 $X=5510 $Y=1640
X36 9 10 9 6 nmos1v_3_CDNS_778095050760 $T=7930 2200 0 0 $X=7510 $Y=1640
X37 8 10 9 2 nmos1v_3_CDNS_778095050760 $T=10020 2200 1 180 $X=9510 $Y=1640
X38 11 8 9 7 nmos1v_3_CDNS_778095050760 $T=12020 2200 1 180 $X=11510 $Y=1640
X39 9 11 9 3 nmos1v_3_CDNS_778095050760 $T=14020 2200 1 180 $X=13510 $Y=1640
X40 9 3 9 8 nmos1v_3_CDNS_778095050760 $T=15930 2200 0 0 $X=15510 $Y=1640
X41 4 3 9 7 nmos1v_3_CDNS_778095050760 $T=18020 2200 1 180 $X=17510 $Y=1640
X42 12 4 9 2 nmos1v_3_CDNS_778095050760 $T=20020 2200 1 180 $X=19510 $Y=1640
X43 9 12 9 5 nmos1v_3_CDNS_778095050760 $T=22020 2200 1 180 $X=21510 $Y=1640
X44 9 5 9 4 nmos1v_3_CDNS_778095050760 $T=23930 2200 0 0 $X=23510 $Y=1640
X45 9 13 9 5 nmos1v_3_CDNS_778095050760 $T=25930 2200 0 0 $X=25510 $Y=1640
X46 14 2 14 1 9 pmos1v_3_CDNS_778095050761 $T=3930 16600 0 0 $X=3510 $Y=16400
X47 14 7 14 2 9 pmos1v_3_CDNS_778095050761 $T=5930 16600 0 0 $X=5510 $Y=16400
X48 14 10 14 6 9 pmos1v_3_CDNS_778095050761 $T=7930 16600 0 0 $X=7510 $Y=16400
X49 8 10 14 7 9 pmos1v_3_CDNS_778095050761 $T=10020 16600 1 180 $X=9510 $Y=16400
X50 11 8 14 2 9 pmos1v_3_CDNS_778095050761 $T=12020 16600 1 180 $X=11510 $Y=16400
X51 14 11 14 3 9 pmos1v_3_CDNS_778095050761 $T=14020 16600 1 180 $X=13510 $Y=16400
X52 14 3 14 8 9 pmos1v_3_CDNS_778095050761 $T=15930 16600 0 0 $X=15510 $Y=16400
X53 4 3 14 2 9 pmos1v_3_CDNS_778095050761 $T=18020 16600 1 180 $X=17510 $Y=16400
X54 12 4 14 7 9 pmos1v_3_CDNS_778095050761 $T=20020 16600 1 180 $X=19510 $Y=16400
X55 14 12 14 5 9 pmos1v_3_CDNS_778095050761 $T=22020 16600 1 180 $X=21510 $Y=16400
X56 14 5 14 4 9 pmos1v_3_CDNS_778095050761 $T=23930 16600 0 0 $X=23510 $Y=16400
X57 14 13 14 5 9 pmos1v_3_CDNS_778095050761 $T=25930 16600 0 0 $X=25510 $Y=16400
.ends TGFF
