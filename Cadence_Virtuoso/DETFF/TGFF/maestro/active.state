ADE simulation setup
Test DETFF_TGFF_1: DETFF/TGFF/schematic, simulator spectre
  Models: /mnt/cadence_tools/gpdk045_v_6_0/gpdk045/../models/spectre/gpdk045.scs[mc]
  Variables: clk_dly = 0; clk_prd = 1n; D_prd = 3n; vdd = 1; D_dly = 0p
  Temperature: 27
  Analysis tran: stop=10n
  Signals: /clk, /D, /Q, /clkb
Run mode: Single Run, Sweeps and Corners
