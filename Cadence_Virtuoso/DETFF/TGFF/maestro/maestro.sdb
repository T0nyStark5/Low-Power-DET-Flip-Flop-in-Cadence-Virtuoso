ADE simulation setup
Run mode: Single Run, Sweeps and Corners
Tests:
  DETFF_TGFF_1: DETFF/TGFF/schematic, simulator spectre
    Variables: clk_dly = 0; clk_prd = 1n; D_prd = 3n; vdd = 1; D_dly = 0p
