ADE simulation setup
Run mode: Single Run, Sweeps and Corners
Tests:
  DETFF_FNC_DET_hold_1: DETFF/FNC_DET_hold/schematic, simulator spectre
    Variables: d_delay = 0; d_prd = 3.53n; vdd = 1; clk_delay = 0; clk_prd = 1n
