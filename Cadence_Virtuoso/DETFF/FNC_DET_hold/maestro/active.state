ADE simulation setup
Test DETFF_FNC_DET_hold_1: DETFF/FNC_DET_hold/schematic, simulator spectre
  Models: /mnt/cadence_tools/gpdk045_v_6_0/gpdk045/../models/spectre/gpdk045.scs[mc]
  Variables: clk_delay = 0; clk_prd = 1n; d_delay = 0; d_prd = 3.53n; vdd = 1
  Temperature: 27
  Analysis tran: stop=10n
  Signals: /CLK, /D, /Q, /CKB, /CKI
Run mode: Single Run, Sweeps and Corners
