* +++++++++++++++++++++++++++++++++++++++++++++++++++++++++ *
* CDL Netlist:                                              *
*                                                           *
* Cell Name  : TGFF                                         *
* Netlisted  : Tue May  5 08:57:23 2026                     *
* PVS Version: 24.10-p035 Thu Aug 22 18:07:17 PDT 2024      *
* +++++++++++++++++++++++++++++++++++++++++++++++++++++++++ *
*.LDD
*.DEVTMPLT 0 MN(g45n1svt) _nmos1v ndiff_conn(D) poly_conn(G) ndiff_conn(S) psubstrate(B)
*.DEVTMPLT 1 MP(g45p1svt) _pmos1v pdiff_conn(D) poly_conn(G) pdiff_conn(S) nwell_conn(B)

* +++++++++++++++++++++++++++++++++++++++++++++++++++++++++ *
* Sub cell: nmos1v_3_CDNS_777985834760                      *
* +++++++++++++++++++++++++++++++++++++++++++++++++++++++++ *
.subckt nmos1v_3_CDNS_777985834760 S_source_0 D_drain_1 B_botTap 4
** N=4 EP=4 FDC=1
M0 D_drain_1 4 S_source_0 B_botTap g45n1svt L=4.5e-08 W=3e-07 AD=4.2e-14 AS=4.2e-14 PD=8.8e-07 PS=8.8e-07 fw=3e-07 sa=1.4e-07 sb=1.4e-07 sca=3.45234 scb=0.000105824 scc=3.48932e-09 $X=0 $Y=0 $dt=0
.ends nmos1v_3_CDNS_777985834760

* +++++++++++++++++++++++++++++++++++++++++++++++++++++++++ *
* Sub cell: pmos1v_3_CDNS_777985834761                      *
* +++++++++++++++++++++++++++++++++++++++++++++++++++++++++ *
.subckt pmos1v_3_CDNS_777985834761 S_source_0 D_drain_1 B_topTap 4
** N=5 EP=4 FDC=1
M0 D_drain_1 4 S_source_0 B_topTap g45p1svt L=4.5e-08 W=6e-07 AD=8.4e-14 AS=8.4e-14 PD=1.48e-06 PS=1.48e-06 fw=6e-07 sa=1.4e-07 sb=1.4e-07 sca=69.3272 scb=0.0652205 scc=0.00809762 $X=0 $Y=0 $dt=1
.ends pmos1v_3_CDNS_777985834761

* +++++++++++++++++++++++++++++++++++++++++++++++++++++++++ *
* Sub cell: TGFF                                            *
* +++++++++++++++++++++++++++++++++++++++++++++++++++++++++ *
.subckt TGFF CLK D Q gnd vdd
** N=14 EP=5 FDC=24
X34 gnd 2 gnd CLK nmos1v_3_CDNS_777985834760 $T=3930 2200 0 0 $X=3510 $Y=1640
X35 gnd 7 gnd 2 nmos1v_3_CDNS_777985834760 $T=5930 2200 0 0 $X=5510 $Y=1640
X36 gnd 10 gnd D nmos1v_3_CDNS_777985834760 $T=7930 2200 0 0 $X=7510 $Y=1640
X37 8 10 gnd 2 nmos1v_3_CDNS_777985834760 $T=10020 2200 1 180 $X=9510 $Y=1640
X38 11 8 gnd 7 nmos1v_3_CDNS_777985834760 $T=12020 2200 1 180 $X=11510 $Y=1640
X39 gnd 11 gnd 3 nmos1v_3_CDNS_777985834760 $T=14020 2200 1 180 $X=13510 $Y=1640
X40 gnd 3 gnd 8 nmos1v_3_CDNS_777985834760 $T=15930 2200 0 0 $X=15510 $Y=1640
X41 4 3 gnd 7 nmos1v_3_CDNS_777985834760 $T=18020 2200 1 180 $X=17510 $Y=1640
X42 12 4 gnd 2 nmos1v_3_CDNS_777985834760 $T=20020 2200 1 180 $X=19510 $Y=1640
X43 gnd 12 gnd 5 nmos1v_3_CDNS_777985834760 $T=22020 2200 1 180 $X=21510 $Y=1640
X44 gnd 5 gnd 4 nmos1v_3_CDNS_777985834760 $T=23930 2200 0 0 $X=23510 $Y=1640
X45 gnd Q gnd 5 nmos1v_3_CDNS_777985834760 $T=25930 2200 0 0 $X=25510 $Y=1640
X46 vdd 2 vdd CLK pmos1v_3_CDNS_777985834761 $T=3930 16600 0 0 $X=3510 $Y=16400
X47 vdd 7 vdd 2 pmos1v_3_CDNS_777985834761 $T=5930 16600 0 0 $X=5510 $Y=16400
X48 vdd 10 vdd D pmos1v_3_CDNS_777985834761 $T=7930 16600 0 0 $X=7510 $Y=16400
X49 8 10 vdd 7 pmos1v_3_CDNS_777985834761 $T=10020 16600 1 180 $X=9510 $Y=16400
X50 11 8 vdd 2 pmos1v_3_CDNS_777985834761 $T=12020 16600 1 180 $X=11510 $Y=16400
X51 vdd 11 vdd 3 pmos1v_3_CDNS_777985834761 $T=14020 16600 1 180 $X=13510 $Y=16400
X52 vdd 3 vdd 8 pmos1v_3_CDNS_777985834761 $T=15930 16600 0 0 $X=15510 $Y=16400
X53 4 3 vdd 2 pmos1v_3_CDNS_777985834761 $T=18020 16600 1 180 $X=17510 $Y=16400
X54 12 4 vdd 7 pmos1v_3_CDNS_777985834761 $T=20020 16600 1 180 $X=19510 $Y=16400
X55 vdd 12 vdd 5 pmos1v_3_CDNS_777985834761 $T=22020 16600 1 180 $X=21510 $Y=16400
X56 vdd 5 vdd 4 pmos1v_3_CDNS_777985834761 $T=23930 16600 0 0 $X=23510 $Y=16400
X57 vdd Q vdd 5 pmos1v_3_CDNS_777985834761 $T=25930 16600 0 0 $X=25510 $Y=16400
.ends TGFF
