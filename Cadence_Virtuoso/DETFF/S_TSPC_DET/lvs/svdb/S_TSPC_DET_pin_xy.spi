* +++++++++++++++++++++++++++++++++++++++++++++++++++++++++ *
* CDL Netlist:                                              *
*                                                           *
* Cell Name  : S_TSPC_DET                                   *
* Netlisted  : Sat May  9 07:12:08 2026                     *
* PVS Version: 24.10-p035 Thu Aug 22 18:07:17 PDT 2024      *
* +++++++++++++++++++++++++++++++++++++++++++++++++++++++++ *
*.LDD
*.DEVTMPLT 0 MN(g45n1svt) _nmos1v ndiff_conn(D) poly_conn(G) ndiff_conn(S) psubstrate(B)
*.DEVTMPLT 1 MP(g45p1svt) _pmos1v pdiff_conn(D) poly_conn(G) pdiff_conn(S) nwell_conn(B)

* +++++++++++++++++++++++++++++++++++++++++++++++++++++++++ *
* Sub cell: M1_PO_CDNS_778325120130                         *
* +++++++++++++++++++++++++++++++++++++++++++++++++++++++++ *
.subckt M1_PO_CDNS_778325120130 1
** N=1 EP=1 FDC=0
.ends M1_PO_CDNS_778325120130

* +++++++++++++++++++++++++++++++++++++++++++++++++++++++++ *
* Sub cell: M2_M1_CDNS_778325120131                         *
* +++++++++++++++++++++++++++++++++++++++++++++++++++++++++ *
.subckt M2_M1_CDNS_778325120131 1
** N=1 EP=1 FDC=0
.ends M2_M1_CDNS_778325120131

* +++++++++++++++++++++++++++++++++++++++++++++++++++++++++ *
* Sub cell: M2_M1_CDNS_778325120132                         *
* +++++++++++++++++++++++++++++++++++++++++++++++++++++++++ *
.subckt M2_M1_CDNS_778325120132 1
** N=1 EP=1 FDC=0
.ends M2_M1_CDNS_778325120132

* +++++++++++++++++++++++++++++++++++++++++++++++++++++++++ *
* Sub cell: M1_PO_CDNS_778325120133                         *
* +++++++++++++++++++++++++++++++++++++++++++++++++++++++++ *
.subckt M1_PO_CDNS_778325120133 1
** N=1 EP=1 FDC=0
.ends M1_PO_CDNS_778325120133

* +++++++++++++++++++++++++++++++++++++++++++++++++++++++++ *
* Sub cell: pmos1v_3_CDNS_778325120130                      *
* +++++++++++++++++++++++++++++++++++++++++++++++++++++++++ *
.subckt pmos1v_3_CDNS_778325120130 1 2 3 4 5
** N=5 EP=5 FDC=1
M0 2 4 1 3 g45p1svt L=4.5e-08 W=6e-07 AD=8.4e-14 AS=8.4e-14 PD=1.48e-06 PS=1.48e-06 fw=6e-07 sa=1.4e-07 sb=1.4e-07 sca=69.3272 scb=0.0652205 scc=0.00809762 $X=0 $Y=0 $dt=1
.ends pmos1v_3_CDNS_778325120130

* +++++++++++++++++++++++++++++++++++++++++++++++++++++++++ *
* Sub cell: nmos1v_3_CDNS_778325120131                      *
* +++++++++++++++++++++++++++++++++++++++++++++++++++++++++ *
.subckt nmos1v_3_CDNS_778325120131 1 2 3 4
** N=4 EP=4 FDC=1
M0 2 4 1 3 g45n1svt L=4.5e-08 W=3e-07 AD=4.2e-14 AS=4.2e-14 PD=8.8e-07 PS=8.8e-07 fw=3e-07 sa=1.4e-07 sb=1.4e-07 sca=3.45234 scb=0.000105824 scc=3.48932e-09 $X=0 $Y=0 $dt=0
.ends nmos1v_3_CDNS_778325120131

* +++++++++++++++++++++++++++++++++++++++++++++++++++++++++ *
* Sub cell: S_TSPC_DET                                      *
* +++++++++++++++++++++++++++++++++++++++++++++++++++++++++ *
.subckt S_TSPC_DET 1 19 2 14 13
** N=24 EP=5 FDC=38
X0 1 M1_PO_CDNS_778325120130 $T=2710 11790 0 0 $X=2610 $Y=11670
X1 2 M1_PO_CDNS_778325120130 $T=4940 17800 0 0 $X=4840 $Y=17680
X2 3 M1_PO_CDNS_778325120130 $T=7900 22520 0 0 $X=7800 $Y=22400
X3 4 M1_PO_CDNS_778325120130 $T=8980 23610 0 0 $X=8880 $Y=23490
X4 5 M1_PO_CDNS_778325120130 $T=13000 5810 0 0 $X=12900 $Y=5690
X5 2 M1_PO_CDNS_778325120130 $T=13760 20880 0 0 $X=13660 $Y=20760
X6 6 M1_PO_CDNS_778325120130 $T=13990 22610 0 0 $X=13890 $Y=22490
X7 4 M1_PO_CDNS_778325120130 $T=14890 21760 0 0 $X=14790 $Y=21640
X8 4 M1_PO_CDNS_778325120130 $T=14970 6810 0 0 $X=14870 $Y=6690
X9 5 M1_PO_CDNS_778325120130 $T=14980 5800 0 0 $X=14880 $Y=5680
X10 5 M1_PO_CDNS_778325120130 $T=16990 5800 0 0 $X=16890 $Y=5680
X11 5 M1_PO_CDNS_778325120130 $T=18920 23610 0 0 $X=18820 $Y=23490
X12 7 M1_PO_CDNS_778325120130 $T=18930 25200 0 0 $X=18830 $Y=25080
X13 2 M1_PO_CDNS_778325120130 $T=19250 20880 0 0 $X=19150 $Y=20760
X14 8 M1_PO_CDNS_778325120130 $T=21020 6840 0 0 $X=20920 $Y=6720
X15 7 M1_PO_CDNS_778325120130 $T=21050 25200 0 0 $X=20950 $Y=25080
X16 2 M1_PO_CDNS_778325120130 $T=22860 20890 0 0 $X=22760 $Y=20770
X17 8 M1_PO_CDNS_778325120130 $T=25110 23380 0 0 $X=25010 $Y=23260
X18 9 M1_PO_CDNS_778325120130 $T=27380 5940 0 0 $X=27280 $Y=5820
X19 8 M1_PO_CDNS_778325120130 $T=27980 23370 0 0 $X=27880 $Y=23250
X20 10 M1_PO_CDNS_778325120130 $T=28150 6880 0 0 $X=28050 $Y=6760
X21 10 M1_PO_CDNS_778325120130 $T=28910 22420 0 0 $X=28810 $Y=22300
X22 10 M1_PO_CDNS_778325120130 $T=28910 24410 0 0 $X=28810 $Y=24290
X23 2 M1_PO_CDNS_778325120130 $T=29160 20890 0 0 $X=29060 $Y=20770
X24 2 M1_PO_CDNS_778325120130 $T=31090 20900 0 0 $X=30990 $Y=20780
X25 10 M1_PO_CDNS_778325120130 $T=33160 5930 0 0 $X=33060 $Y=5810
X26 11 M1_PO_CDNS_778325120130 $T=34110 21840 0 0 $X=34010 $Y=21720
X27 2 M1_PO_CDNS_778325120130 $T=34150 20900 0 0 $X=34050 $Y=20780
X28 11 M1_PO_CDNS_778325120130 $T=34620 6870 0 0 $X=34520 $Y=6750
X29 12 M1_PO_CDNS_778325120130 $T=39380 15000 0 0 $X=39280 $Y=14880
X30 12 M2_M1_CDNS_778325120131 $T=18190 5790 0 0 $X=18110 $Y=5660
X31 9 M2_M1_CDNS_778325120131 $T=20500 7780 0 0 $X=20420 $Y=7650
X32 12 M2_M1_CDNS_778325120131 $T=21780 5790 0 0 $X=21700 $Y=5660
X33 9 M2_M1_CDNS_778325120131 $T=26190 7780 0 0 $X=26110 $Y=7650
X34 1 M2_M1_CDNS_778325120132 $T=5070 8590 0 0 $X=4990 $Y=8340
X35 2 M2_M1_CDNS_778325120132 $T=7340 20890 0 0 $X=7260 $Y=20640
X36 2 M2_M1_CDNS_778325120132 $T=11240 20880 0 0 $X=11160 $Y=20630
X37 1 M2_M1_CDNS_778325120132 $T=37020 8590 0 0 $X=36940 $Y=8340
X38 1 M1_PO_CDNS_778325120133 $T=5070 8590 0 0 $X=4970 $Y=8340
X39 2 M1_PO_CDNS_778325120133 $T=7340 20890 0 0 $X=7240 $Y=20640
X40 2 M1_PO_CDNS_778325120133 $T=11240 20880 0 0 $X=11140 $Y=20630
X41 1 M1_PO_CDNS_778325120133 $T=37020 8590 0 0 $X=36920 $Y=8340
X42 13 3 13 1 14 pmos1v_3_CDNS_778325120130 $T=3940 24600 0 0 $X=3520 $Y=24400
X43 15 3 13 2 14 pmos1v_3_CDNS_778325120130 $T=6030 24600 1 180 $X=5520 $Y=24400
X44 13 15 13 4 14 pmos1v_3_CDNS_778325120130 $T=8030 24600 1 180 $X=7520 $Y=24400
X45 13 4 13 3 14 pmos1v_3_CDNS_778325120130 $T=9940 24600 0 0 $X=9520 $Y=24400
X46 16 4 13 2 14 pmos1v_3_CDNS_778325120130 $T=12030 24600 1 180 $X=11520 $Y=24400
X47 13 16 13 6 14 pmos1v_3_CDNS_778325120130 $T=14030 24600 1 180 $X=13520 $Y=24400
X48 13 6 13 4 14 pmos1v_3_CDNS_778325120130 $T=15940 24600 0 0 $X=15520 $Y=24400
X49 13 7 13 5 14 pmos1v_3_CDNS_778325120130 $T=17940 24600 0 0 $X=17520 $Y=24400
X50 6 5 13 2 14 pmos1v_3_CDNS_778325120130 $T=20030 24600 1 180 $X=19520 $Y=24400
X51 7 12 13 2 14 pmos1v_3_CDNS_778325120130 $T=21940 24600 0 0 $X=21520 $Y=24400
X52 13 12 13 8 14 pmos1v_3_CDNS_778325120130 $T=24030 24600 1 180 $X=23520 $Y=24400
X53 13 8 13 10 14 pmos1v_3_CDNS_778325120130 $T=25940 24600 0 0 $X=25520 $Y=24400
X54 13 10 13 8 14 pmos1v_3_CDNS_778325120130 $T=27940 24600 0 0 $X=27520 $Y=24400
X55 13 8 13 2 14 pmos1v_3_CDNS_778325120130 $T=30030 24600 1 180 $X=29520 $Y=24400
X56 13 17 13 11 14 pmos1v_3_CDNS_778325120130 $T=31940 24600 0 0 $X=31520 $Y=24400
X57 17 10 13 2 14 pmos1v_3_CDNS_778325120130 $T=33940 24600 0 0 $X=33520 $Y=24400
X58 18 11 13 2 14 pmos1v_3_CDNS_778325120130 $T=36030 24600 1 180 $X=35520 $Y=24400
X59 13 18 13 1 14 pmos1v_3_CDNS_778325120130 $T=38030 24600 1 180 $X=37520 $Y=24400
X60 13 19 13 12 14 pmos1v_3_CDNS_778325120130 $T=39940 24600 0 0 $X=39520 $Y=24400
X61 14 20 14 1 nmos1v_3_CDNS_778325120131 $T=3940 4200 0 0 $X=3520 $Y=3640
X62 20 3 14 2 nmos1v_3_CDNS_778325120131 $T=5940 4200 0 0 $X=5520 $Y=3640
X63 21 4 14 2 nmos1v_3_CDNS_778325120131 $T=8030 4200 1 180 $X=7520 $Y=3640
X64 14 21 14 3 nmos1v_3_CDNS_778325120131 $T=10030 4200 1 180 $X=9520 $Y=3640
X65 14 5 14 2 nmos1v_3_CDNS_778325120131 $T=11940 4200 0 0 $X=11520 $Y=3640
X66 14 4 14 5 nmos1v_3_CDNS_778325120131 $T=13940 4200 0 0 $X=13520 $Y=3640
X67 14 5 14 4 nmos1v_3_CDNS_778325120131 $T=15940 4200 0 0 $X=15520 $Y=3640
X68 14 12 14 5 nmos1v_3_CDNS_778325120131 $T=17940 4200 0 0 $X=17520 $Y=3640
X69 9 8 14 2 nmos1v_3_CDNS_778325120131 $T=19940 4200 0 0 $X=19520 $Y=3640
X70 22 12 14 2 nmos1v_3_CDNS_778325120131 $T=22030 4200 1 180 $X=21520 $Y=3640
X71 14 22 14 8 nmos1v_3_CDNS_778325120131 $T=24030 4200 1 180 $X=23520 $Y=3640
X72 14 9 14 10 nmos1v_3_CDNS_778325120131 $T=25940 4200 0 0 $X=25520 $Y=3640
X73 14 23 14 9 nmos1v_3_CDNS_778325120131 $T=27940 4200 0 0 $X=27520 $Y=3640
X74 23 10 14 2 nmos1v_3_CDNS_778325120131 $T=29940 4200 0 0 $X=29520 $Y=3640
X75 14 10 14 11 nmos1v_3_CDNS_778325120131 $T=32030 4200 1 180 $X=31520 $Y=3640
X76 14 24 14 10 nmos1v_3_CDNS_778325120131 $T=33940 4200 0 0 $X=33520 $Y=3640
X77 24 11 14 2 nmos1v_3_CDNS_778325120131 $T=35940 4200 0 0 $X=35520 $Y=3640
X78 14 11 14 1 nmos1v_3_CDNS_778325120131 $T=38030 4200 1 180 $X=37520 $Y=3640
X79 14 19 14 12 nmos1v_3_CDNS_778325120131 $T=39940 4200 0 0 $X=39520 $Y=3640
.ends S_TSPC_DET
