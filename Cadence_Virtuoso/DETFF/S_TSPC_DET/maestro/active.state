ADE simulation setup
Test DETFF_S_TSPC_DET_1: DETFF/S_TSPC_DET/schematic, simulator spectre
  Models: /mnt/cadence_tools/gpdk045_v_6_0/gpdk045/../models/spectre/gpdk045.scs[mc]
  Variables: clk_dly = 300p; clk_prd = 1n; D_dly = 0; D_prd = 3n; vdd = 1
  Temperature: 27
  Analysis tran: stop=15n
  Signals: /clk, /D, /Q
Run mode: Single Run, Sweeps and Corners
