ADE simulation setup
Test DETFF_FNC_DET_tb_1: DETFF/FNC_DET_tb/schematic, simulator spectre
  Models: /mnt/cadence_tools/gpdk045_v_6_0/gpdk045/../models/spectre/gpdk045.scs[mc]
  Variables: D_dly = 1100p; Cap = 1f; clk_dly = 100p; clk_prd = 1n; D_prd = 10n; vdd = 1
  Temperature: 27
  Analysis tran: stop=20n
  Output average((VT("/vdd") * IT("/I0/vdd")))
  Signals: /clk, /D, /Q, /vdd, /I0/vdd (terminal)
Run mode: Single Run, Sweeps and Corners
Corners:
  model folders: /mnt/cadence_tools/gpdk045_v_6_0/models/spectre
  C0: temperature=27; Cap=1f; D_prd=10n; clk_dly=100p; clk_prd=1n; vdd=1; D_dly=1100p; gpdk045.scs[tt sf fs]
  C1: temperature=-40; Cap=1f; D_prd=10n; clk_dly=100p; clk_prd=1n; vdd=1.1; D_dly=1100p; gpdk045.scs[ff]
  C2: temperature=120; Cap=1f; D_prd=10n; clk_dly=100p; clk_prd=1n; vdd=0.9; D_dly=1100p; gpdk045.scs[ss]
