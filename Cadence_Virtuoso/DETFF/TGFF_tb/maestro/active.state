ADE simulation setup
Test DETFF_TGFF_tb_1: DETFF/TGFF_tb/schematic, simulator spectre
  Models: /mnt/cadence_tools/gpdk045_v_6_0/gpdk045/../models/spectre/gpdk045.scs[mc]
  Variables: cap = 1f; CLK_dly = 0; CLK_prd = 0.5n; D_dly = 0; D_prd = 5n; vdd = 1
  Temperature: 27
  Analysis tran: stop=10n
  Output average((VT("/vdd") * IT("/I0/vdd")))
  Signals: /CLK, /D, /Q, /vdd, /I0/vdd (terminal)
Run mode: Single Run, Sweeps and Corners
Corners:
  model folders: /mnt/cadence_tools/gpdk045_v_6_0/models/spectre
  C0: temperature=27; CLK_dly=0; CLK_prd=0.5n; D_dly=0; D_prd=5n; cap=1f; vdd=1; gpdk045.scs[tt sf fs]
  C1: temperature=-40; CLK_dly=0; CLK_prd=0.5n; D_dly=0; D_prd=5n; cap=1f; vdd=1.1; gpdk045.scs[ff]
  C2: temperature=120; CLK_dly=0; CLK_prd=0.5n; D_dly=0; D_prd=5n; cap=1f; vdd=0.9; gpdk045.scs[ss]
