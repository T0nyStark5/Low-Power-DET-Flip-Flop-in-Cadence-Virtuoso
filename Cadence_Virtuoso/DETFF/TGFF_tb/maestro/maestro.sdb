ADE simulation setup
Run mode: Single Run, Sweeps and Corners
Tests:
  DETFF_TGFF_tb_1: DETFF/TGFF_tb/schematic, simulator spectre
    Variables: cap = 1f; CLK_dly = 0; CLK_prd = 0.5n; D_dly = 0; D_prd = 5n; vdd = 1
Corners:
  model folders: /mnt/cadence_tools/gpdk045_v_6_0/models/spectre
  C0: temperature=27; CLK_dly=0; CLK_prd=0.5n; D_dly=0; D_prd=5n; cap=1f; vdd=1; gpdk045.scs[tt sf fs]
  C1: temperature=-40; CLK_dly=0; CLK_prd=0.5n; D_dly=0; D_prd=5n; cap=1f; vdd=1.1; gpdk045.scs[ff]
  C2: temperature=120; CLK_dly=0; CLK_prd=0.5n; D_dly=0; D_prd=5n; cap=1f; vdd=0.9; gpdk045.scs[ss]
