ADE simulation setup
Run mode: Single Run, Sweeps and Corners
Tests:
  DETFF_Threshold_Test_1: DETFF/Threshold_Test/schematic, simulator spectre
    Variables: vgs = {From/To}Linear:0.4:0.1:0.9{From/To}
