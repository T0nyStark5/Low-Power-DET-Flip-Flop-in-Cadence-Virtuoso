ADE simulation setup
Test DETFF_Threshold_Test_1: DETFF/Threshold_Test/schematic, simulator spectre
  Models: /mnt/cadence_tools/gpdk045_v_6_0/gpdk045/../models/spectre/gpdk045.scs[mc]
  Variables: vgs = {From/To}Linear:0.4:0.1:0.9{From/To}
  Temperature: 27
  Analysis dc: (saves the operating point)
  Analysis tran: stop=2n
  Output IT("/NM0/D")
  Signals: /NM0/D (terminal)
Run mode: Single Run, Sweeps and Corners
