ADE simulation setup
Run mode: Single Run, Sweeps and Corners
Tests:
  DETFF_S_DET_tb_1: DETFF/S_DET_tb/schematic, simulator spectre
    Variables: CLK_delay = 100p; CLK_prd = 1n; D_prd = 10n; vdd = 1; D_delay = 1100p; c = 1f
Corners:
  model folders: /mnt/cadence_tools/gpdk045_v_6_0/models/spectre
  C0: temperature=27; CLK_delay=100p; CLK_prd=1n; D_delay=1.1n; D_prd=10n; vdd=1; c=1f; gpdk045.scs[tt sf fs]
  C1: temperature=-40; CLK_delay=100p; CLK_prd=1n; D_delay=1.1n; D_prd=10n; vdd=1.1; c=1f; gpdk045.scs[ff]
  C2: temperature=120; CLK_delay=100p; CLK_prd=1n; D_delay=1.1n; D_prd=10n; vdd=0.9; c=1f; gpdk045.scs[ss]
