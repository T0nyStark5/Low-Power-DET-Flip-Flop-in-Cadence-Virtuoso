ADE simulation setup
Run mode: Single Run, Sweeps and Corners
Tests:
  DETFF_TGFF_hold_1: DETFF/TGFF_hold/schematic, simulator spectre
    Variables: CLK_dly = 500p; CLK_prd = 0.5n; D_dly = 0; D_prd = 3.53n; vdd = 1
