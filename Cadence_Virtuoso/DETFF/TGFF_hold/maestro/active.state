ADE simulation setup
Test DETFF_TGFF_hold_1: DETFF/TGFF_hold/schematic, simulator spectre
  Models: /mnt/cadence_tools/gpdk045_v_6_0/gpdk045/../models/spectre/gpdk045.scs[mc]
  Variables: CLK_dly = 500p; CLK_prd = 0.5n; D_dly = 0; D_prd = 3.53n; vdd = 1
  Temperature: 27
  Analysis tran: stop=10n
  Signals: /CLK, /D, /Q, /CLKB, /CLKA
Run mode: Single Run, Sweeps and Corners
