ADE simulation setup
Run mode: Single Run, Sweeps and Corners
Tests:
  DETFF_S_DET_1: DETFF/S_DET/schematic, simulator spectre
    Variables: clk_dly = 400p; clk_prd = 1n; D_prd = 5.1n; vdd = 1
