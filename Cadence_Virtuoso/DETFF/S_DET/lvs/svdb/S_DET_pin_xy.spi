* +++++++++++++++++++++++++++++++++++++++++++++++++++++++++ *
* CDL Netlist:                                              *
*                                                           *
* Cell Name  : S_DET                                        *
* Netlisted  : Wed Apr 15 06:18:50 2026                     *
* PVS Version: 24.10-p035 Thu Aug 22 18:07:17 PDT 2024      *
* +++++++++++++++++++++++++++++++++++++++++++++++++++++++++ *
*.LDD
*.DEVTMPLT 0 MN(g45n1svt) _nmos1v ndiff_conn(D) poly_conn(G) ndiff_conn(S) psubstrate(B)
*.DEVTMPLT 1 MP(g45p1svt) _pmos1v pdiff_conn(D) poly_conn(G) pdiff_conn(S) nwell_conn(B)

* +++++++++++++++++++++++++++++++++++++++++++++++++++++++++ *
* Sub cell: M1_PO_CDNS_776248330160                         *
* +++++++++++++++++++++++++++++++++++++++++++++++++++++++++ *
.subckt M1_PO_CDNS_776248330160 1
** N=1 EP=1 FDC=0
.ends M1_PO_CDNS_776248330160

* +++++++++++++++++++++++++++++++++++++++++++++++++++++++++ *
* Sub cell: M2_M1_CDNS_776248330161                         *
* +++++++++++++++++++++++++++++++++++++++++++++++++++++++++ *
.subckt M2_M1_CDNS_776248330161 1
** N=1 EP=1 FDC=0
.ends M2_M1_CDNS_776248330161

* +++++++++++++++++++++++++++++++++++++++++++++++++++++++++ *
* Sub cell: M2_M1_CDNS_776248330162                         *
* +++++++++++++++++++++++++++++++++++++++++++++++++++++++++ *
.subckt M2_M1_CDNS_776248330162 1
** N=1 EP=1 FDC=0
.ends M2_M1_CDNS_776248330162

* +++++++++++++++++++++++++++++++++++++++++++++++++++++++++ *
* Sub cell: M1_PO_CDNS_776248330163                         *
* +++++++++++++++++++++++++++++++++++++++++++++++++++++++++ *
.subckt M1_PO_CDNS_776248330163 1
** N=1 EP=1 FDC=0
.ends M1_PO_CDNS_776248330163

* +++++++++++++++++++++++++++++++++++++++++++++++++++++++++ *
* Sub cell: pmos1v_3_CDNS_776248330160                      *
* +++++++++++++++++++++++++++++++++++++++++++++++++++++++++ *
.subckt pmos1v_3_CDNS_776248330160 1 2 3 4 5
** N=5 EP=5 FDC=1
M0 2 4 1 3 g45p1svt L=4.5e-08 W=6e-07 AD=8.4e-14 AS=8.4e-14 PD=1.48e-06 PS=1.48e-06 fw=6e-07 sa=1.4e-07 sb=1.4e-07 sca=69.3272 scb=0.0652205 scc=0.00809762 $X=0 $Y=0 $dt=1
.ends pmos1v_3_CDNS_776248330160

* +++++++++++++++++++++++++++++++++++++++++++++++++++++++++ *
* Sub cell: nmos1v_3_CDNS_776248330161                      *
* +++++++++++++++++++++++++++++++++++++++++++++++++++++++++ *
.subckt nmos1v_3_CDNS_776248330161 1 2 3 4
** N=4 EP=4 FDC=1
M0 2 4 1 3 g45n1svt L=4.5e-08 W=3e-07 AD=4.2e-14 AS=4.2e-14 PD=8.8e-07 PS=8.8e-07 fw=3e-07 sa=1.4e-07 sb=1.4e-07 sca=3.45234 scb=0.000105824 scc=3.48932e-09 $X=0 $Y=0 $dt=0
.ends nmos1v_3_CDNS_776248330161

* +++++++++++++++++++++++++++++++++++++++++++++++++++++++++ *
* Sub cell: S_DET                                           *
* +++++++++++++++++++++++++++++++++++++++++++++++++++++++++ *
.subckt S_DET 1 7 14 9 8
** N=16 EP=5 FDC=26
X0 1 M1_PO_CDNS_776248330160 $T=3770 10000 0 0 $X=3670 $Y=9880
X1 2 M1_PO_CDNS_776248330160 $T=5920 10000 0 0 $X=5820 $Y=9880
X2 3 M1_PO_CDNS_776248330160 $T=7290 15610 0 0 $X=7190 $Y=15490
X3 4 M1_PO_CDNS_776248330160 $T=9500 15610 0 0 $X=9400 $Y=15490
X4 4 M1_PO_CDNS_776248330160 $T=9520 3790 0 0 $X=9420 $Y=3670
X5 5 M1_PO_CDNS_776248330160 $T=19550 3790 0 0 $X=19450 $Y=3670
X6 5 M1_PO_CDNS_776248330160 $T=19560 15610 0 0 $X=19460 $Y=15490
X7 6 M1_PO_CDNS_776248330160 $T=27890 10000 0 0 $X=27790 $Y=9880
X8 2 M2_M1_CDNS_776248330161 $T=5550 14000 0 0 $X=5470 $Y=13870
X9 3 M2_M1_CDNS_776248330161 $T=7450 6000 0 0 $X=7370 $Y=5870
X10 7 M2_M1_CDNS_776248330161 $T=7450 10000 0 0 $X=7370 $Y=9870
X11 6 M2_M1_CDNS_776248330161 $T=17430 8000 0 0 $X=17350 $Y=7870
X12 7 M2_M1_CDNS_776248330161 $T=17460 10000 0 0 $X=17380 $Y=9870
X13 6 M2_M1_CDNS_776248330161 $T=27160 8000 0 0 $X=27080 $Y=7870
X14 3 M2_M1_CDNS_776248330162 $T=14470 6000 0 0 $X=14390 $Y=5750
X15 2 M2_M1_CDNS_776248330162 $T=14470 14000 0 0 $X=14390 $Y=13750
X16 2 M2_M1_CDNS_776248330162 $T=24910 14000 0 0 $X=24830 $Y=13750
X17 3 M2_M1_CDNS_776248330162 $T=25460 6000 0 0 $X=25380 $Y=5750
X18 3 M1_PO_CDNS_776248330163 $T=14470 6000 0 0 $X=14370 $Y=5750
X19 2 M1_PO_CDNS_776248330163 $T=14470 14000 0 0 $X=14370 $Y=13750
X20 2 M1_PO_CDNS_776248330163 $T=24910 14000 0 0 $X=24810 $Y=13750
X21 3 M1_PO_CDNS_776248330163 $T=25460 6000 0 0 $X=25360 $Y=5750
X22 8 2 8 1 9 pmos1v_3_CDNS_776248330160 $T=4420 16600 0 0 $X=4000 $Y=16400
X23 8 3 8 2 9 pmos1v_3_CDNS_776248330160 $T=6420 16600 0 0 $X=6000 $Y=16400
X24 7 4 8 3 9 pmos1v_3_CDNS_776248330160 $T=8420 16600 0 0 $X=8000 $Y=16400
X25 8 10 8 4 9 pmos1v_3_CDNS_776248330160 $T=10420 16600 0 0 $X=10000 $Y=16400
X26 11 10 8 4 9 pmos1v_3_CDNS_776248330160 $T=12510 16600 1 180 $X=12000 $Y=16400
X27 8 11 8 2 9 pmos1v_3_CDNS_776248330160 $T=14510 16600 1 180 $X=14000 $Y=16400
X28 10 6 8 2 9 pmos1v_3_CDNS_776248330160 $T=16420 16600 0 0 $X=16000 $Y=16400
X29 7 5 8 2 9 pmos1v_3_CDNS_776248330160 $T=18420 16600 0 0 $X=18000 $Y=16400
X30 8 12 8 5 9 pmos1v_3_CDNS_776248330160 $T=20420 16600 0 0 $X=20000 $Y=16400
X31 13 12 8 5 9 pmos1v_3_CDNS_776248330160 $T=22510 16600 1 180 $X=22000 $Y=16400
X32 8 13 8 3 9 pmos1v_3_CDNS_776248330160 $T=24510 16600 1 180 $X=24000 $Y=16400
X33 12 6 8 3 9 pmos1v_3_CDNS_776248330160 $T=26420 16600 0 0 $X=26000 $Y=16400
X34 8 14 8 6 9 pmos1v_3_CDNS_776248330160 $T=28420 16600 0 0 $X=28000 $Y=16400
X35 9 2 9 1 nmos1v_3_CDNS_776248330161 $T=4420 2200 0 0 $X=4000 $Y=1640
X36 9 3 9 2 nmos1v_3_CDNS_776248330161 $T=6420 2200 0 0 $X=6000 $Y=1640
X37 4 7 9 2 nmos1v_3_CDNS_776248330161 $T=8510 2200 1 180 $X=8000 $Y=1640
X38 9 10 9 4 nmos1v_3_CDNS_776248330161 $T=10420 2200 0 0 $X=10000 $Y=1640
X39 15 10 9 4 nmos1v_3_CDNS_776248330161 $T=12510 2200 1 180 $X=12000 $Y=1640
X40 9 15 9 3 nmos1v_3_CDNS_776248330161 $T=14510 2200 1 180 $X=14000 $Y=1640
X41 6 10 9 3 nmos1v_3_CDNS_776248330161 $T=16510 2200 1 180 $X=16000 $Y=1640
X42 5 7 9 3 nmos1v_3_CDNS_776248330161 $T=18510 2200 1 180 $X=18000 $Y=1640
X43 9 12 9 5 nmos1v_3_CDNS_776248330161 $T=20420 2200 0 0 $X=20000 $Y=1640
X44 16 12 9 5 nmos1v_3_CDNS_776248330161 $T=22510 2200 1 180 $X=22000 $Y=1640
X45 9 16 9 2 nmos1v_3_CDNS_776248330161 $T=24510 2200 1 180 $X=24000 $Y=1640
X46 6 12 9 2 nmos1v_3_CDNS_776248330161 $T=26510 2200 1 180 $X=26000 $Y=1640
X47 9 14 9 6 nmos1v_3_CDNS_776248330161 $T=28420 2200 0 0 $X=28000 $Y=1640
.ends S_DET
