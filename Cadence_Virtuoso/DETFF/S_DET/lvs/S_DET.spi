* +++++++++++++++++++++++++++++++++++++++++++++++++++++++++ *
* CDL Netlist:                                              *
*                                                           *
* Cell Name  : S_DET                                        *
* Netlisted  : Wed Apr 15 06:18:50 2026                     *
* PVS Version: 24.10-p035 Thu Aug 22 18:07:17 PDT 2024      *
* +++++++++++++++++++++++++++++++++++++++++++++++++++++++++ *
*.LDD
*.DEVTMPLT 0 MN(g45n1svt) _nmos1v ndiff_conn(D) poly_conn(G) ndiff_conn(S) psubstrate(B)
*.DEVTMPLT 1 MP(g45p1svt) _pmos1v pdiff_conn(D) poly_conn(G) pdiff_conn(S) nwell_conn(B)

* +++++++++++++++++++++++++++++++++++++++++++++++++++++++++ *
* Sub cell: pmos1v_3_CDNS_776248330160                      *
* +++++++++++++++++++++++++++++++++++++++++++++++++++++++++ *
.subckt pmos1v_3_CDNS_776248330160 S_source_0 D_drain_1 B_topTap 4
** N=5 EP=4 FDC=1
M0 D_drain_1 4 S_source_0 B_topTap g45p1svt L=4.5e-08 W=6e-07 AD=8.4e-14 AS=8.4e-14 PD=1.48e-06 PS=1.48e-06 fw=6e-07 sa=1.4e-07 sb=1.4e-07 sca=69.3272 scb=0.0652205 scc=0.00809762 $X=0 $Y=0 $dt=1
.ends pmos1v_3_CDNS_776248330160

* +++++++++++++++++++++++++++++++++++++++++++++++++++++++++ *
* Sub cell: nmos1v_3_CDNS_776248330161                      *
* +++++++++++++++++++++++++++++++++++++++++++++++++++++++++ *
.subckt nmos1v_3_CDNS_776248330161 S_source_0 D_drain_1 B_botTap 4
** N=4 EP=4 FDC=1
M0 D_drain_1 4 S_source_0 B_botTap g45n1svt L=4.5e-08 W=3e-07 AD=4.2e-14 AS=4.2e-14 PD=8.8e-07 PS=8.8e-07 fw=3e-07 sa=1.4e-07 sb=1.4e-07 sca=3.45234 scb=0.000105824 scc=3.48932e-09 $X=0 $Y=0 $dt=0
.ends nmos1v_3_CDNS_776248330161

* +++++++++++++++++++++++++++++++++++++++++++++++++++++++++ *
* Sub cell: S_DET                                           *
* +++++++++++++++++++++++++++++++++++++++++++++++++++++++++ *
.subckt S_DET CLK D Q gnd vdd
** N=16 EP=5 FDC=26
X22 vdd 2 vdd CLK pmos1v_3_CDNS_776248330160 $T=4420 16600 0 0 $X=4000 $Y=16400
X23 vdd 3 vdd 2 pmos1v_3_CDNS_776248330160 $T=6420 16600 0 0 $X=6000 $Y=16400
X24 D 4 vdd 3 pmos1v_3_CDNS_776248330160 $T=8420 16600 0 0 $X=8000 $Y=16400
X25 vdd 10 vdd 4 pmos1v_3_CDNS_776248330160 $T=10420 16600 0 0 $X=10000 $Y=16400
X26 11 10 vdd 4 pmos1v_3_CDNS_776248330160 $T=12510 16600 1 180 $X=12000 $Y=16400
X27 vdd 11 vdd 2 pmos1v_3_CDNS_776248330160 $T=14510 16600 1 180 $X=14000 $Y=16400
X28 10 6 vdd 2 pmos1v_3_CDNS_776248330160 $T=16420 16600 0 0 $X=16000 $Y=16400
X29 D 5 vdd 2 pmos1v_3_CDNS_776248330160 $T=18420 16600 0 0 $X=18000 $Y=16400
X30 vdd 12 vdd 5 pmos1v_3_CDNS_776248330160 $T=20420 16600 0 0 $X=20000 $Y=16400
X31 13 12 vdd 5 pmos1v_3_CDNS_776248330160 $T=22510 16600 1 180 $X=22000 $Y=16400
X32 vdd 13 vdd 3 pmos1v_3_CDNS_776248330160 $T=24510 16600 1 180 $X=24000 $Y=16400
X33 12 6 vdd 3 pmos1v_3_CDNS_776248330160 $T=26420 16600 0 0 $X=26000 $Y=16400
X34 vdd Q vdd 6 pmos1v_3_CDNS_776248330160 $T=28420 16600 0 0 $X=28000 $Y=16400
X35 gnd 2 gnd CLK nmos1v_3_CDNS_776248330161 $T=4420 2200 0 0 $X=4000 $Y=1640
X36 gnd 3 gnd 2 nmos1v_3_CDNS_776248330161 $T=6420 2200 0 0 $X=6000 $Y=1640
X37 4 D gnd 2 nmos1v_3_CDNS_776248330161 $T=8510 2200 1 180 $X=8000 $Y=1640
X38 gnd 10 gnd 4 nmos1v_3_CDNS_776248330161 $T=10420 2200 0 0 $X=10000 $Y=1640
X39 15 10 gnd 4 nmos1v_3_CDNS_776248330161 $T=12510 2200 1 180 $X=12000 $Y=1640
X40 gnd 15 gnd 3 nmos1v_3_CDNS_776248330161 $T=14510 2200 1 180 $X=14000 $Y=1640
X41 6 10 gnd 3 nmos1v_3_CDNS_776248330161 $T=16510 2200 1 180 $X=16000 $Y=1640
X42 5 D gnd 3 nmos1v_3_CDNS_776248330161 $T=18510 2200 1 180 $X=18000 $Y=1640
X43 gnd 12 gnd 5 nmos1v_3_CDNS_776248330161 $T=20420 2200 0 0 $X=20000 $Y=1640
X44 16 12 gnd 5 nmos1v_3_CDNS_776248330161 $T=22510 2200 1 180 $X=22000 $Y=1640
X45 gnd 16 gnd 2 nmos1v_3_CDNS_776248330161 $T=24510 2200 1 180 $X=24000 $Y=1640
X46 6 12 gnd 2 nmos1v_3_CDNS_776248330161 $T=26510 2200 1 180 $X=26000 $Y=1640
X47 gnd Q gnd 6 nmos1v_3_CDNS_776248330161 $T=28420 2200 0 0 $X=28000 $Y=1640
.ends S_DET
