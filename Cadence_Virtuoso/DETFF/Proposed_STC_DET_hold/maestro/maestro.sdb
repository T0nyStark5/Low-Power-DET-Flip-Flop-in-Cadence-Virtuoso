ADE simulation setup
Run mode: Single Run, Sweeps and Corners
Tests:
  DETFF_Proposed_STC_DET_hold_1: DETFF/Proposed_STC_DET_hold/schematic, simulator spectre
    Variables: clk_dly = 500p; clk_prd = 1n; D_dly = 0p; D_prd = 3.53n; vdd = 1
